`include "disciplines.vams"
`include "constants.vams"

/**
 * @module brillouin_dampener
 * @brief Active Phase Cancellation for Brillouin scattering protection
 * @author CIC - Complexo Integrado CORVO
 */
module brillouin_dampener(
    input  opt_ref,      // optical reference signal (from a photodiode)
    output eom_drive,    // electrical drive for an electro‑optic modulator
    output status        // analog voltage indicating lock status (0 = off, 1 = locked)
);

    electrical opt_ref, eom_drive, status;

    // ============================================================
    // Parameters (user‑adjustable)
    // ============================================================
    parameter real center_wavelength = 674e-9;   // meter (Brillouin laser wavelength)
    parameter real loop_gain = 1e6;              // PI controller gain (V/rad)
    parameter real integrator_time = 1e-6;       // integrator time constant (seconds)
    parameter real output_amplitude = 1.0;       // peak output voltage (V)
    parameter real lock_threshold = 0.1;         // phase error below which status goes high (rad)

    // ============================================================
    // Internal signals
    // ============================================================
    real phase_error;          // measured phase difference (rad)
    real integrator;           // integrator state for PI controller
    real control_signal;       // output of PI controller (rad)
    real cancel_phase;         // phase to be applied to the output
    real optical_frequency;    // 2πc/λ

    // ============================================================
    // Analog behaviour
    // ============================================================
    analog begin
        @(initial_step) begin
            integrator = 0.0;
            optical_frequency = 2 * `M_PI * `P_C / center_wavelength;
        end

        // 1. Assume opt_ref is the phase error voltage (1V = 1rad)
        // In a real system, this would be derived from a photodiode bridge.
        phase_error = V(opt_ref);

        // 2. PI controller
        // Using idt() for integration in Verilog-A
        integrator = idt(phase_error, 0.0) / integrator_time;
        control_signal = loop_gain * (phase_error + integrator);

        // 3. The canceling phase is the inverse of the input phase (180° shift)
        cancel_phase = control_signal + `M_PI;   // add π radians (180°)

        // 4. Generate output voltage for the electro‑optic modulator (EOM)
        V(eom_drive) <+ output_amplitude * sin(cancel_phase);

        // 5. Status output: lock indicator (1 when phase error is small)
        if (abs(phase_error) < lock_threshold)
            V(status) <+ 1.0;
        else
            V(status) <+ 0.0;
    end

endmodule
