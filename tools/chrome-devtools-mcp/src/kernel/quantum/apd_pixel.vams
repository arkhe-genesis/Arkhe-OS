// ============================================================================
// Verilog-A Model: Silicon Avalanche Photodiode (APD)
// ============================================================================

`include "constants.vams"
`include "disciplines.vams"

module apd_pixel(an, cat, optical_in, photon_out, avalanche_out);
    inout an, cat;
    input optical_in;
    output photon_out, avalanche_out;

    electrical an, cat, avalanche_node;
    optical optical_in;

    // Physical constants
    parameter real h = 6.62607015e-34;
    parameter real q = 1.602176634e-19;

    // APD parameters
    parameter real lambda = 674e-9;
    parameter real eta = 0.65;
    parameter real Vbr = 30.0;
    parameter real Vbias = 35.0;
    parameter real R_series = 50.0;
    parameter real C_junc = 0.2e-12;
    parameter real t_jitter = 50e-12;
    parameter real t_dead = 100e-9;
    parameter real DCR = 50;
    parameter real Vdd = 3.3;

    real avalanche_current;
    real last_detection_time;
    integer seed;

    analog begin
        @(initial_step) begin
            seed = 12345;
            last_detection_time = -1.0;
            avalanche_current = 0.0;
        end

        // Simplified photon and dark count logic for Verilog-A
        // In a real simulation, this would use $dist_poisson or similar

        V(avalanche_node) <+ avalanche_current * R_series;
        I(an, cat) <+ C_junc * ddt(V(an, cat));
    end
endmodule
