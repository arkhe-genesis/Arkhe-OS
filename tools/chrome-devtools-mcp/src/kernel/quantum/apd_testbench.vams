// ============================================================================
// Testbench: APD Single-Photon Detection Verification
// ============================================================================

`timescale 1ns / 1ps
`include "constants.vams"
`include "disciplines.vams"

module tb_apd;
    electrical an, cat;
    wire photon_out;
    wire avalanche_out;
    optical optical_in;

    // Instance of APD
    apd_pixel dut(an, cat, optical_in, photon_out, avalanche_out);

    initial begin
        $display("[TB] Starting APD statistical validation...");
        #1000000;
        $display("[TB] Test complete!");
        $finish;
    end
endmodule
