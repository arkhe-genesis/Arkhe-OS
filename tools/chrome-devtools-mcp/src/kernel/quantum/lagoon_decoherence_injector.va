`include "disciplines.vams"
`include "constants.vams"

/**
 * @module lagoon_decoherence_injector
 * @brief Active Decoherence Injection for the Lagoon Phase Shield (Phase 1.5)
 * @author CIC - Complexo Integrado CORVO
 */
module lagoon_decoherence_injector(
    input  v_ctrl,       // control voltage from the coordination network
    output noise_out,    // electrical output for the QCL (Quantum Cascade Laser)
    output status        // status indicator (1 = active injection)
);

    electrical v_ctrl, noise_out, status;

    // ============================================================
    // Parameters
    // ============================================================
    parameter real pi_gain = 1e7;                // High-speed PI loop gain
    parameter real f_min = 100.0;               // Min injection frequency (Hz)
    parameter real f_max = 1500.0;              // Max injection frequency (Hz)
    parameter real noise_amplitude = 2.0;       // Output amplitude (V)
    parameter real integration_time = 1e-7;     // Integration time constant (s)

    // ============================================================
    // Internal Variables
    // ============================================================
    real phi;                   // Instantaneous phase
    real inst_freq;             // Instantaneous frequency
    integer seed;               // Random number seed
    real biological_noise;      // 1/f-like colorful noise component

    // ============================================================
    // Behavior
    // ============================================================
    analog begin
        @(initial_step) begin
            phi = 0.0;
            seed = 42; // Seed for the stochastic process
        end

        // 1. Generate 1/f-like biological noise using a simple Markov process
        // In a real system, this hides the actual population signal.
        biological_noise = white_noise(1.0, "bio_entropy");
        biological_noise = idt(biological_noise, 0.0) * 0.1; // Integrator creates 1/f spectrum

        // 2. Frequency sweep logic (100Hz to 1.5kHz)
        // We use a triangle wave or random walk for the frequency to disrupt AI prediction.
        inst_freq = f_min + (f_max - f_min) * (0.5 + 0.5 * sin(2 * `M_PI * 0.5 * $abstime));

        // 3. Phase Integration
        phi = idt(2 * `M_PI * inst_freq, 0.0) + biological_noise;

        // 4. PI Loop Response to Control Voltage
        // High gain allows for near-instantaneous phase tracking/inversion if needed.
        // For injection, we treat v_ctrl as a phase offset.
        V(noise_out) <+ noise_amplitude * sin(phi + pi_gain * V(v_ctrl));

        // 5. Status Output
        V(status) <+ 1.0;
    end

endmodule
