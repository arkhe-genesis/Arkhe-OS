`include "disciplines.vams"
`include "constants.vams"

/**
 * @module bip_mini_sensor
 * @brief Miniaturized APD-based Phase Sensor for Liquid Biopsy (Oncology Expansion)
 * @author CIC - Complexo Integrado CORVO
 */
module bip_mini_sensor(
    input  v_in,         // Input from photodiode bridge (mV)
    output v_phase,      // Demodulated phase signal (V)
    output status        // Status indicator (1 = stable acquisition)
);

    electrical v_in, v_phase, status;

    // ============================================================
    // Parameters
    // ============================================================
    parameter real sampling_rate = 200.0;       // Hz
    parameter real sensitivity = 0.5;           // V/rad
    parameter real noise_floor = 1e-6;          // V/√Hz
    parameter real ppg_center_freq = 1.25;      // Hz (75 BPM)

    // ============================================================
    // Internal Signals
    // ============================================================
    real raw_signal;
    real theta_extracted;
    real stability_score;

    // ============================================================
    // Behavior
    // ============================================================
    analog begin
        // 1. Capture and Filter the Biological Signal
        // In reality, this uses a high-gain TIA + Bandpass filter.
        raw_signal = V(v_in) + white_noise(noise_floor, "dark_current");

        // 2. Phase Extraction (Simulated Hilbert Transform / Quadrature)
        // Extract the phase of the dominant PPG/CTC frequency component.
        theta_extracted = idt(2 * `M_PI * ppg_center_freq, 0.0) + (raw_signal * sensitivity);

        // 3. Stability Tracking
        // Coherence is high if the signal variance matches human physiological ranges.
        stability_score = 1.0 - (abs(raw_signal) > 1.0 ? 0.5 : 0.0);

        // 4. Output Mapping
        V(v_phase) <+ sensitivity * sin(theta_extracted);

        // 5. Status Output: High when signal is within readable range
        if (stability_score > 0.8)
            V(status) <+ 5.0; // 5V High
        else
            V(status) <+ 0.0;
    end

endmodule
